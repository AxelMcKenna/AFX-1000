E12 native THS4551 left-stage conditional vendor simulation
.include "/private/tmp/afx-ths4551-sbomb92b/ths4551.lib"
V5 V5_REG 0 5
VNEG NBIAS_L 0 -0.23
VCM VOCM_L 0 1.65
VIN BUF_L 0 DC 0 AC 1
R1 BUF_L FB_P_L 2490
R2 0 FB_N_L 2490
R3 ADC_LN FB_P_L 1210
R4 ADC_LP FB_N_L 1210
R5 DRV_LP ADC_LP 3.32
R6 DRV_LN ADC_LN 3.32
C1 DRV_LN FB_P_L 1e-12
C2 DRV_LP FB_N_L 1e-12
C3 ADC_LP ADC_LN 4.7e-11
C4 ADC_LP 0 2.2e-11
C5 ADC_LN 0 2.2e-11
XFDA FB_P_L FB_N_L DRV_LP DRV_LN VOCM_L V5_REG NBIAS_L THS4551
RLP ADC_LP 0 260
RLN ADC_LN 0 260
.temp 27
.dc VIN -6 6 0.25
.end
