opa192_tina_1mohm_feedback_hypothesis
.include "/private/tmp/afx-opa192-tina/OPAx192.LIB"
VP P12 0 12
VN N12 0 -12
VIN IN 0 DC 1.65 AC 1
RLOAD OUT 0 2000
RTRACE OUT FB 0.001
XAMP IN FB P12 N12 OUT OPAx192
.temp 27
.ac dec 20 10 100Meg
.end
