opa1656_tina_ideal_feedback
.include "/private/tmp/afx-opa1656-tina/OPA1656.LIB"
VP P12 0 12
VN N12 0 -12
VIN IN 0 DC 1.65 AC 1
RLOAD OUT 0 2000
XAMP IN OUT P12 N12 OUT OPA1656
.temp 27
.ac dec 20 10 100Meg
.end
