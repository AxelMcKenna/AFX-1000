E12-R2 coupled buffer/reference/common-mode conditional model
.include "/private/tmp/afx-ths4551-model/ths4551.lib"
V5 V5_REG 0 5
VN NBIAS_L 0 -.23
VL LOADREF 0 1.65
R1 BUF_L FB_P_L 2490
R2 0 FB_N_L 2490
R3 SENSE_LN FB_P_L 1210
R4 SENSE_LP FB_N_L 1210
R5 DRV_LP ADC_LP 3.3
R6 DRV_LN ADC_LN 3.3
C1 DRV_LN FB_P_L 1e-12
C2 DRV_LP FB_N_L 1e-12
C3 ADC_LP ADC_LN 4.7e-11
C4 ADC_LP 0 2.2e-11
C5 ADC_LN 0 2.2e-11
XFDA FB_P_L FB_N_L DRV_LP DRV_LN VOCM_L V5_REG NBIAS_L THS4551
RWP ADC_LP LINEP 0.001
LWP LINEP SENSE_LP 5e-10
RLP SENSE_LP LOADREF 260
RWN ADC_LN LINEN 0.001
LWN LINEN SENSE_LN 5e-10
RLN SENSE_LN LOADREF 260
.temp 27
.include "/private/tmp/afx-opa192-model/OPAx192.LIB"
.include "/private/tmp/afx-opa1656-model/OPA1656.LIB"
VP12 P12 0 12
VN12 N12 0 -12
VIN PRE_OUT_L 0 DC 0 AC 0
VREF REF_ADC1 0 DC 3.3 AC 1
R7 PRE_OUT_L 0 1000000
R8 REF_ADC1 REF_DIV_L 100000
R9 REF_DIV_L 0 100000
R10 SENSE_LP CM_SENSE_L 10000
R11 SENSE_LN CM_SENSE_L 10000
R12 CM_DRIVE_L CM_SENSE_L 10000000
R13 CM_DRIVE_L VOCM_L 10000
C6 REF_DIV_L 0 1e-07
C7 CM_DRIVE_L CM_SENSE_L 1.1e-06
XBUFFER PRE_OUT_L BUF_L P12 N12 BUF_L OPA1656
XREFHALF REF_DIV_L REF_HALF_L P12 N12 REF_HALF_L OPAx192
XCMSERVO REF_HALF_L CM_SENSE_L P12 N12 CM_DRIVE_L OPAx192
.ac dec 40 .01 100Meg
.end
