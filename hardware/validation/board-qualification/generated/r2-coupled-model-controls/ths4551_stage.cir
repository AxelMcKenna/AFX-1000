E12-R2 declared Kelvin interface stage
.include "/private/tmp/afx-ths4551-model/ths4551.lib"
V5 V5_REG 0 5
VN NBIAS_L 0 -.23
VC VOCM_L 0 1.65
VIN BUF_L 0 DC 0 AC 1
VL LOADREF 0 1.65
R1 BUF_L FB_P_L 2490
R2 0 FB_N_L 2490
R3 SENSE_LN FB_P_L 1210
R4 SENSE_LP FB_N_L 1210
R5 DRV_LP ADC_LP 3.3
R6 DRV_LN ADC_LN 3.3
C1 DRV_LN FB_P_L 1e-12
C2 DRV_LP FB_N_L 1e-12
C3 ADC_LP ADC_LN 4.7e-11
C4 ADC_LP 0 2.2e-11
C5 ADC_LN 0 2.2e-11
XFDA FB_P_L FB_N_L DRV_LP DRV_LN VOCM_L V5_REG NBIAS_L THS4551
RWP ADC_LP LINEP 0.001
LWP LINEP SENSE_LP 5e-10
RLP SENSE_LP LOADREF 260
RWN ADC_LN LINEN 0.001
LWN LINEN SENSE_LN 5e-10
RLN SENSE_LN LOADREF 260
.temp 27
.ac dec 20 10 100Meg
.end
